* pm6V_TEC_vbe_tracking.cir   (LTspice)
* ---------------------------------------------------------------------------
* Purpose: verify the two 1N4148 forward drops (D_CP + D10/D11) track the two
*          Vbe drops (driver + output follower) across temperature, so the
*          +/-6V_TEC rails stay near +/-6 V.
*
* HOW TO RUN in LTspice:
*   1. File > Open  ->  this .cir file  (set filter to "All Files" if needed)
*   2. Run (the running-man icon).
*   3. In the plot pane, click the node names  vout  and  voutn  (or right-click
*      the plot > Add Traces).  X-axis = temperature; you get 3 traces each,
*      one per load current (0.1 / 1.5 / 3.0 A).  Flat traces = good tracking.
*      (If the x-axis shows ILOAD instead of temp, swap the order of the two
*       .step lines below.)
*   4. To see the +rail tracking error directly, Add Trace:  V(drvb)-V(vref)
*      (= the 2 diode drops) and  V(drvb)-V(e1)  (= the 2 Vbe).  Their gap is
*      the tracking error; if it barely moves 0..75 C, the comp is good.
*
* Models: 1N4148 / 2N2222 / 2N2907 are standard.  MJL21194/MJL21193 are
*         APPROXIMATE -- paste the ON Semi vendor models over the two lines
*         marked  <<< REPLACE >>>  for final accuracy.
* ---------------------------------------------------------------------------

.op
.step temp 0 75 5
.step param ILOAD list 0.10 1.50 3.00

*=================== POSITIVE RAIL (+6V_TEC) ================================
Vraw    raw    0   10.5         ; filtered raw from + cap-multiplier (~+10.5 V)
Vrawf   rawf   0   10.5         ; same rail feeding the output-pair collectors

R26     raw    drvb   1.5k      ; bias resistor (raw -> driver-base node)
Dcp1    drvb   mid    D1N4148   ; Vbe-comp diode 1  (anode = drvb)
D10     mid    vref   D1N4148   ; Vbe-comp diode 2  (cathode = vref = +6.2 V)
Vref    vref   0   6.2          ; LM4040-6.2 modeled as ideal 6.2 V shunt ref
*                                 (LM4040 tempco ~100 ppm/C -> negligible here)
Qdrv    raw    drvb   pbase   MMBT2222          ; NPN driver  (C B E)
Qo1     rawf   pbase  e1      Qmjl21194         ; output pair, device 1
Qo2     rawf   pbase  e2      Qmjl21194         ; output pair, device 2
Rb1     e1     vout   0.1                       ; emitter ballast
Rb2     e2     vout   0.1                       ; emitter ballast
Iload   vout   0   {ILOAD}      ; load: + rail SOURCES this current

*=================== NEGATIVE RAIL (-6V_TEC) ================================
Vrawn   rawn   0   -10.5
Vrawfn  rawfn  0   -10.5
R27     rawn   drvbn  1.5k
Dcp2    midn   drvbn  D1N4148   ; (anode = midn, higher potential)
D11     vrefn  midn   D1N4148   ; (anode = vrefn = -6.2 V)
Vrefn   vrefn  0   -6.2         ; negative LM4040 ref (-6.2 V)
Qdrvn   rawn   drvbn  pbasen  MMBT2907          ; PNP driver  (C B E)
Qon1    rawfn  pbasen en1     Qmjl21193
Qon2    rawfn  pbasen en2     Qmjl21193
Rbn1    en1    voutn  0.1
Rbn2    en2    voutn  0.1
Iloadn  0      voutn  {ILOAD}   ; load on the negative rail

*=================== MODELS =================================================
.model D1N4148 D(IS=4.352E-9 N=1.906 RS=0.6458 BV=110 IBV=1E-4
+ CJO=7.048E-13 VJ=0.869 M=0.03 FC=0.5 TT=3.48E-9 EG=1.11 XTI=3)

.model MMBT2222 NPN(Is=14.34f Xti=3 Eg=1.11 Vaf=74.03 Bf=255.9 Ne=1.307
+ Ise=14.34f Ikf=.2847 Xtb=1.5 Br=6.092 Nc=2 Isc=0 Ikr=0 Rc=1 Cjc=7.306p
+ Mjc=.3416 Vjc=.75 Fc=.5 Cje=22.01p Mje=.377 Vje=.75 Tr=46.91n Tf=411.1p
+ Itf=.6 Vtf=1.7 Xtf=3 Rb=10)

.model MMBT2907 PNP(Is=650.6E-18 Xti=3 Eg=1.11 Vaf=115.7 Bf=231.9 Ne=1.829
+ Ise=54.81f Ikf=1.079 Xtb=1.5 Br=3.563 Nc=2 Isc=0 Ikr=0 Rc=.715 Cjc=14.76p
+ Mjc=.5383 Vjc=.75 Fc=.5 Cje=19.82p Mje=.3357 Vje=.75 Tr=111.3n Tf=603.7p
+ Itf=.65 Vtf=5 Xtf=1.7 Rb=10)

* ON Semi vendor models (model names: Qmjl21194 NPN, Qmjl21193 PNP)
.include MJL21194.LIB
.include MJL21193.LIB

.end
